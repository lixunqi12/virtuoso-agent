;;; psf_dump_worker.ocn — standalone OCEAN worker for PSF dumping.
;;;
;;; Invoked by Python OceanWorker (see src/ocean_worker.py):
;;;
;;;   setenv VB_PSF_DIR      /path/to/psf
;;;   setenv VB_SPEC_FILE    /tmp/vb_spec_<uuid>.il
;;;   setenv VB_RESULT_JSON  /tmp/vb_result_<uuid>.json
;;;   setenv VB_SKILL_DIR    /remote/path/to/virtuoso-agent/skill
;;;   ocean -nograph -restore <this file>
;;;
;;; VB_SPEC_FILE is a SKILL file generated by Python. It defines two
;;; global lists that this worker consumes:
;;;
;;;   vbSignalList = '( (sigName sigKind (path1 [path2])) ... )
;;;   vbWindowList = '( (winName tStart tEnd) ... )
;;;   vbOscSignals = '( pathP pathN )                  ; optional (may be nil)
;;;
;;; Format matches safeOceanDumpAll(signalList windowList) so we reuse
;;; the validated helpers from safe_ocean.il instead of re-implementing
;;; stats logic.
;;;
;;; Outputs:
;;;   stdout         : one line JSON status: {"status":"ok"} or
;;;                    {"status":"error","msg":"..."}
;;;   VB_RESULT_JSON : full dump JSON on success; file absent on error.
;;;
;;; Exit codes:
;;;   0 on success (stdout status == ok AND result file written)
;;;   1 on env / spec / openResults failure
;;;
;;; Design notes:
;;; - Every OCEAN primitive that can hang or raise is errset-wrapped.
;;; - We do NOT call run() — PSF must already exist (produced by the
;;;   main virtuoso session via safeOceanRun).
;;; - unselectResult() is called at the end so if OCEAN stays around
;;;   for any reason (it shouldn't — we exit) the selection is clean.
;;;

;;; ----- small local helpers (cannot assume helpers.il is loaded yet) -----

procedure(vbWorker_getenvOrDie(name)
    let((v)
        v = getShellEnvVar(name)
        when(or(null(v) and(stringp(v) equal(v "")))
            fprintf(stderr "[psf_dump_worker] ERROR: env %s not set\n" name)
            printf("{\"status\":\"error\",\"msg\":\"missing env %s\"}\n" name)
            exit(1)
        )
        v
    )
)

procedure(vbWorker_writeStatus(statusStr msgStr)
    ;; One-line status to stdout — Python parses this to decide pass/fail
    ;; quickly without opening the result file.
    if(msgStr
        printf("{\"status\":\"%s\",\"msg\":\"%s\"}\n" statusStr msgStr)
        printf("{\"status\":\"%s\"}\n" statusStr)
    )
)

procedure(vbWorker_writeFile(path content)
    let((h)
        h = outfile(path "w")
        when(null(h)
            fprintf(stderr "[psf_dump_worker] ERROR: cannot open %s for write\n" path)
            vbWorker_writeStatus("error" strcat("cannot open " path))
            exit(1)
        )
        fprintf(h "%s" content)
        close(h)
        t
    )
)

;;; ----- main -----

let((psfDir specFile resultJson skillDir
     loadOk openOk selectOk jsonStr errMsg)

    ;; 1) resolve required env vars
    psfDir     = vbWorker_getenvOrDie("VB_PSF_DIR")
    specFile   = vbWorker_getenvOrDie("VB_SPEC_FILE")
    resultJson = vbWorker_getenvOrDie("VB_RESULT_JSON")
    skillDir   = vbWorker_getenvOrDie("VB_SKILL_DIR")

    fprintf(stderr "[psf_dump_worker] psfDir=%s\n" psfDir)
    fprintf(stderr "[psf_dump_worker] specFile=%s\n" specFile)
    fprintf(stderr "[psf_dump_worker] skillDir=%s\n" skillDir)

    ;; 2) load supporting SKILL libs (validated primitives in safe_ocean.il)
    loadOk = errset(load(strcat(skillDir "/helpers.il")))
    when(null(loadOk)
        vbWorker_writeStatus("error" "failed to load helpers.il")
        exit(1)
    )
    loadOk = errset(load(strcat(skillDir "/safe_ocean.il")))
    when(null(loadOk)
        vbWorker_writeStatus("error" "failed to load safe_ocean.il")
        exit(1)
    )

    ;; 3) load spec file — defines vbSignalList + vbWindowList
    loadOk = errset(load(specFile))
    when(null(loadOk)
        vbWorker_writeStatus("error" strcat("failed to load spec " specFile))
        exit(1)
    )
    unless(boundp('vbSignalList)
        vbWorker_writeStatus("error" "spec did not define vbSignalList")
        exit(1)
    )
    unless(boundp('vbWindowList)
        vbWorker_writeStatus("error" "spec did not define vbWindowList")
        exit(1)
    )
    unless(listp(vbSignalList)
        vbWorker_writeStatus("error" "vbSignalList is not a list")
        exit(1)
    )
    unless(listp(vbWindowList)
        vbWorker_writeStatus("error" "vbWindowList is not a list")
        exit(1)
    )
    fprintf(stderr "[psf_dump_worker] %d signal(s), %d window(s)\n"
            length(vbSignalList) length(vbWindowList))

    ;; 4) open PSF directory
    fprintf(stderr "[psf_dump_worker] T=%s step4_openResults_begin psfDir=%s\n" getCurrentTime() psfDir)
    openOk = errset(openResults(psfDir))
    fprintf(stderr "[psf_dump_worker] T=%s step4_openResults_end ok=%L\n" getCurrentTime() openOk)
    when(null(openOk)
        vbWorker_writeStatus("error" strcat("openResults failed for " psfDir))
        exit(1)
    )

    ;; 5) select tran — wrapped in errset, but if this hangs the Python
    ;; launcher will wall-clock-kill the whole process. No attempt to
    ;; recover: we trust the kill.
    fprintf(stderr "[psf_dump_worker] T=%s step5_selectResult_begin\n" getCurrentTime())
    selectOk = errset(selectResult('tran))
    fprintf(stderr "[psf_dump_worker] T=%s step5_selectResult_end ok=%L\n" getCurrentTime() selectOk)
    when(null(selectOk)
        vbWorker_writeStatus("error" "selectResult('tran) failed")
        exit(1)
    )

    ;; 5b) DC / early-time snapshot — diagnostic for DC-latch hypothesis.
    ;; If Vout_p and Vout_n are both stuck near rail with large |Vdiff|,
    ;; the cross-coupled pair has latched and the waveform is degenerate.
    ;; Best-effort (each value() wrapped in errset); failures are logged
    ;; but do not abort — this is diagnostic-only.
    fprintf(stderr "[psf_dump_worker] T=%s step5b_dc_snapshot_begin\n" getCurrentTime())
    let((vp0 vn0 vp1ns vn1ns)
        vp0   = errset(value(VT("/Vout_p") 0.0))
        vn0   = errset(value(VT("/Vout_n") 0.0))
        vp1ns = errset(value(VT("/Vout_p") 1.0e-9))
        vn1ns = errset(value(VT("/Vout_n") 1.0e-9))
        fprintf(stderr "[psf_dump_worker] T=%s DC_snapshot Vp0=%L Vn0=%L Vp1ns=%L Vn1ns=%L\n"
                getCurrentTime() vp0 vn0 vp1ns vn1ns)
    )
    fprintf(stderr "[psf_dump_worker] T=%s step5b_dc_snapshot_end\n" getCurrentTime())

    ;; 5c) oscillation gate — general check: if caller supplied
    ;; vbOscSignals = (pathP pathN), we compute ptp(VT(pathP) - VT(pathN))
    ;; and short-circuit when below 100 mV. This protects cross-based
    ;; stats (frequency, dutyFromCross) from infinite-looping on near-DC
    ;; waveforms. Applies to any topology whose caller designates a
    ;; differential output pair.
    fprintf(stderr "[psf_dump_worker] T=%s step5c_osc_gate_begin\n" getCurrentTime())
    unless(boundp('vbOscSignals)
        setq(vbOscSignals nil)
    )
    when(and(vbOscSignals listp(vbOscSignals) equal(length(vbOscSignals) 2))
        let((sigP sigN wpRes wnRes vdiffRes ymaxRes yminRes
             vpp oscThresh doSkip)
            oscThresh = 0.1  ;; 100 mV — differential peak-to-peak threshold
            sigP = nth(0 vbOscSignals)
            sigN = nth(1 vbOscSignals)
            doSkip = nil
            wpRes = errset(VT(sigP) t)
            wnRes = errset(VT(sigN) t)
            when(and(wpRes wnRes car(wpRes) car(wnRes))
                vdiffRes = errset(car(wpRes) - car(wnRes) t)
                when(and(vdiffRes car(vdiffRes))
                    ymaxRes = errset(ymax(car(vdiffRes)) t)
                    yminRes = errset(ymin(car(vdiffRes)) t)
                    when(and(ymaxRes yminRes
                             numberp(car(ymaxRes)) numberp(car(yminRes)))
                        vpp = car(ymaxRes) - car(yminRes)
                        fprintf(stderr "[psf_dump_worker] osc_gate sigP=%s sigN=%s Vpp=%L thresh=%L\n"
                                sigP sigN vpp oscThresh)
                        when(lessp(vpp oscThresh)
                            doSkip = t
                        )
                    )
                )
            )
            when(doSkip
                fprintf(stderr "[psf_dump_worker] T=%s osc_gate: non_oscillating — skipping dumpAll (Vpp=%L < %L)\n"
                        getCurrentTime() vpp oscThresh)
                when(isCallable('unselectResult)
                    errset(unselectResult() t)
                )
                ;; Emit ok=true so _fetch_result accepts it; the
                ;; "degenerate" flag tells the Python side this iter
                ;; produced no measurements (circuit not oscillating).
                vbWorker_writeFile(resultJson
                    "{\"ok\":true,\"degenerate\":true,\"reason\":\"not_oscillating\",\"dumps\":{}}")
                vbWorker_writeStatus("ok" nil)
                exit(0)
            )
        )
    )
    fprintf(stderr "[psf_dump_worker] T=%s step5c_osc_gate_end\n" getCurrentTime())

    ;; 6) delegate to the existing validated dump routine. This returns
    ;; a JSON string in the same schema as the SKILL path. No need to
    ;; reinvent stats logic — behaviour is bit-identical.
    fprintf(stderr "[psf_dump_worker] T=%s step6_dumpAll_begin\n" getCurrentTime())
    jsonStr = nil
    errMsg  = errset(jsonStr = safeOceanDumpAll(vbSignalList vbWindowList))
    fprintf(stderr "[psf_dump_worker] T=%s step6_dumpAll_end errMsg=%L type=%L\n"
            getCurrentTime() errMsg if(jsonStr then "string" else "nil"))
    when(null(errMsg)
        when(isCallable('unselectResult)
            errset(unselectResult() t)
        )
        vbWorker_writeStatus("error" "safeOceanDumpAll raised")
        exit(1)
    )
    unless(stringp(jsonStr)
        when(isCallable('unselectResult)
            errset(unselectResult() t)
        )
        vbWorker_writeStatus("error" "safeOceanDumpAll returned non-string")
        exit(1)
    )

    ;; 7) write result file + one-line stdout status
    when(isCallable('unselectResult)
        errset(unselectResult() t)
    )
    vbWorker_writeFile(resultJson jsonStr)
    vbWorker_writeStatus("ok" nil)

    ;; 8) exit cleanly — releases Affirma_sim_analysis_env seat
    exit(0)
)
